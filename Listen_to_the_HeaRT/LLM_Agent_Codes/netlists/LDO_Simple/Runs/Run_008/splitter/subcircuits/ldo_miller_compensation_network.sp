.subckt ldo_miller_compensation_network net7 vo
R0 net1 vo res r0
C0 net7 net1 cap c0
.ends ldo_miller_compensation_network
