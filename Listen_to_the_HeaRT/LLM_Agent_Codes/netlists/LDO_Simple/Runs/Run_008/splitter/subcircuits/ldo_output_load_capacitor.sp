.subckt ldo_output_load_capacitor vo GND
CL vo GND cap cload
.ends ldo_output_load_capacitor
