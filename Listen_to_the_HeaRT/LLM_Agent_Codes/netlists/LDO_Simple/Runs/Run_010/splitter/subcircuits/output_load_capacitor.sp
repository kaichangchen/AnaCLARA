.subckt output_load_capacitor vo GND
CL vo GND cap cload
.ends output_load_capacitor
