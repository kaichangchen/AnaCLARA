simulator( 'spectre )
design(	 "/home/polaris/souradip18/simulation/test_ldo/spectre/schematic/netlist/netlist")
resultsDir( "/home/polaris/souradip18/simulation/test_ldo/spectre/schematic" )
modelFile(
    '("/usr/local/packages/tsmc_40/pdk/tsmcN40/../models/spectre/toplevel.scs" "top_tt")
)
analysis('dc ?saveOppoint t  )
analysis('ac ?start "0.1"  ?stop "10G"  ?dec "10"  )
analysis('stb ?start "0.1"  ?stop "10G"  ?dec "10"
		?probe "/IPRB0"  ?localgnd "/GND"  )
desVar(	  "vref" 0.8	)
desVar(	  "vdd" 1.8	)
desVar(	  "ib" 100n	)
desVar(	  "rl" 10M	)
desVar(	  "cl" 50f	)
desVar(	  "rz" 1K	)
desVar(	  "rd" 600K	)
desVar(	  "l_cs_p" 2u	)
desVar(	  "l_eab_p" 500n	)
desVar(	  "l_eai_p" 500n	)
desVar(	  "l_eal_n" 500n	)
desVar(	  "l_power_p" 500n	)
desVar(	  "lcc" 10u	)
desVar(	  "n_rd" 1	)
desVar(	  "n_rz" 1	)
desVar(	  "w_cs_p" 4u	)
desVar(	  "w_eab_p" 4u	)
desVar(	  "w_eai_p" 4u	)
desVar(	  "w_eal_n" 2u	)
desVar(	  "w_power_p" 100u	)
desVar(	  "wcc" 10u	)
envOption(
	'analysisOrder  list("dc" "ac" "stb")
)
save( 'i "/I2/vdd" "/R0/PLUS" )
temp( 27 )
run()
IQ_A = (IDC("/I2/vdd") - IDC("/R0/PLUS"))
plot( IQ_A ?expr '( "IQ_A" ) )
dropout_voltage_V = (VDC("/VDD") - VDC("/vo"))
plot( dropout_voltage_V ?expr '( "dropout_voltage_V" ) )
Phase_Margin = getData("phaseMargin" ?result "stb_margin")
plot( Phase_Margin ?expr '( "Phase_Margin" ) )
Loop_Gain_dB20 = db(mag(getData("loopGain" ?result "stb")))
plot( Loop_Gain_dB20 ?expr '( "Loop_Gain_dB20" ) )
Loop_Gain_Phase = phaseDegUnwrapped(getData("loopGain" ?result "stb"))
plot( Loop_Gain_Phase ?expr '( "Loop_Gain_Phase" ) )
PSR = db(vfreq('ac "/vo"))
plot( PSR ?expr '( "PSR" ) )
loopgain_dc_dB = average(clip(db(mag(getData("loopGain" ?result "stb"))) 1 10000))
plot( loopgain_dc_dB ?expr '( "loopgain_dc_dB" ) )
PSR_worsecase_dB = ymax(db(vfreq('ac "/vo")))
plot( PSR_worsecase_dB ?expr '( "PSR_worsecase_dB" ) )
iout_A = IDC("/R0/PLUS")
plot( iout_A ?expr '( "iout_A" ) )
vo_V = VDC("/vo")
plot( vo_V ?expr '( "vo_V" ) )
