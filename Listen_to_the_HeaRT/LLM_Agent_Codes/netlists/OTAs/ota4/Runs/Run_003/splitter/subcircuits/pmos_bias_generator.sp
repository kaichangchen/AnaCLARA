.subckt pmos_bias_generator ib_sink vdd
M6 ib_sink ib_sink vdd vdd pch l=lp_tail w=wp_tail m=1 nf=1
.ends pmos_bias_generator
